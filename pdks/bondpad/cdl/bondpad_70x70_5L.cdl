.SUBCKT bondpad_70x70_5L pad
*.PININFO pad:B
.ENDS
